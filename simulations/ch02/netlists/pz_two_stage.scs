simulator lang=spectre
global 0
Vin (vin 0) vsource dc=0 mag=1
// CASE two_stage: two_stage
VCCS151 (two_stage_x 0 vin 0) vccs gm=0.002
RESISTOR152 (two_stage_x 0) resistor r=50000
VCCS153 (two_stage 0 two_stage_x 0) vccs gm=0.004
RESISTOR154 (two_stage 0) resistor r=50000
CAPACITOR155 (two_stage_x 0) capacitor c=1e-12
CAPACITOR156 (two_stage_x two_stage) capacitor c=3e-12
CAPACITOR157 (two_stage 0) capacitor c=5e-12

poles (two_stage 0) pz iprobe=Vin docancel=no
ac ac start=1 stop=1T dec=10
save two_stage
saveOptions options save=selected
