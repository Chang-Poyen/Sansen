simulator lang=spectre
global 0
Vin (vin 0) vsource dc=0 mag=1
// CASE follower_center: follower
RESISTOR78 (vin follower_center_g) resistor r=10000
VCCS79 (0 follower_center follower_center_g follower_center) vccs gm=0.002
CAPACITOR80 (follower_center_g follower_center) capacitor c=1e-12
CAPACITOR81 (follower_center_g 0) capacitor c=2e-13
CAPACITOR82 (0 follower_center) capacitor c=3e-12

poles (follower_center 0) pz iprobe=Vin docancel=no
ac ac start=1 stop=1T dec=10
save follower_center
saveOptions options save=selected
